`include "nature_fluid_dynamics.vams"

module MembraneValve(fl_in,
		     fl_out,
		     air_in,
		     air_out,
             	c_in,
             	c_out);

inout fl_in, fl_out;
inout c_in, c_out;
input air_in;
output air_out;

//Define connections
branch (fl_in, fl_out) fl_br;
branch (air_in, air_out) a_br;

//input fl_port1; tried
//output fl_port2;

fluidDynamics fl_in,fl_out, air_in, air_out;
concentration c_in, c_out;
// tried declaring air port electrical

// Valve dimensional properties in pixels
parameter real dia=20, mem_th = 2;

parameter real nu = 0.8891m;

// inlet and outlet channel properties
// parameter real ch_h = 5, ch_w = 6, pn_h= 5, pn_w = 6;
// Total channel length into valve
parameter real L = 1.0m;

// Valve threshold for closing
parameter real theshold = 103k; //Pa // 15 PSI

// Standard pixel sizes
parameter real px_size = 7.6u, layer_h = 10u;
parameter real chan = 1;

/*
if(chan == 1)
    // standard 1
    real H = 5, W = 6;
else if (chan == 2)
    // standard 2
    real H = 8, W = 14;
*/
// validating test px size
parameter real H = 5, W = 6;

// Valve standard size 20px
real dia_m = px_size*dia;
real mem_th_m = layer_h*mem_th;

// converts the channel size from px/layer to meters
real Lm = L,
     Hm = H*layer_h,
     Wm = W*px_size;
real R_valve = (12*nu*Lm)/(1 - 0.63*(Hm/Wm)) * 1/(Hm*Hm*Hm/Wm);

// Create branches

initial begin
$display("nu = %f, L = %f, H = %f, W = %f", nu, Lm, Hm, Wm);
$display("R = %f", R_valve);
$display("P_a_br = %f", P(a_br));
end
// ground delcaration
//ground gnd;

// output
// normally open valve
analog begin
    if (P(a_br) < theshold)
        //Q(fl_br) <+ P(fl_br)/R_valve;
	Q(fl_br) <+ P(fl_br)/R_valve;//
    else
        Q(fl_br) <+ 0;

    if (P(a_br) < theshold)
        C(c_out)  <+ C(c_in);
    else
        C(c_out) <+ 0;
        // TODO
        // This will be dependent on likely the previous state
end

endmodule
