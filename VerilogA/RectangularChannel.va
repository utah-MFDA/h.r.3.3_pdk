// Sophia Nielsen, sophi.nieslen@utah.edu
`include "nature_fluid_dynamics"

// preset channel cross section

// (1) channel cross section for default channel (for easy manufacturing/3D printing)
// 8 layers tall, 14 pixels wide
// pixel size:  7.6 microns, layer size:  10  microns

// (2) channel cross section for smaller channels
// 5 layers tall, 6 pixels wide
// pixel size:  7.6 microns, layer size:  10  microns

module RectangularChannel(fluid_port_1, fluid_port_2);
` // input and output ports of channel
  // fluid_port_1 - input port for pressure and flow, conservative
  // fluid_port_2 - output port for pressure and flow, conservative
  input fluid_port_1;
  output fluid_port_2;
  // declared  wiith fluidDynamics discipline
  fluidDynamics fluid_port_1, fluid_port_2;

// channel length (l - length (m))
// fluid viscosity (nu - dynamic viscosity)
// CROSS_SECTION - 1 for default channel, 2 for small channel
  parameter real L;
  parameter real NU = 0.8891;
  parameter real CROSS_SECTION;

  initial begin
    if (CROSS_SECTION == 1) {
      real width_pixels = 14;
      real hieght_layers = 8;
    }
    else if(CROSS_SECTION == 2){
      real width_pixels = 6;
      real hieght_layers = 5;
    }
    real microns_per_pixel = 7.6;
    real microns_per_layer = 10;
    real meters_per_micron = .000001;

    real W = width_pixels*microns_per_pixel*meters_per_micron;
    real H = hieght_layers*microns_per_layer*meters_per_micron;

    // Channel cross section (w - width, h - hieght),
    real R_hyd = (12*NU*L)/(1 - 0.63*(H/W)) * 1/(H*H*H/W);
  end

  analog begin
    Q(fluid_port_1,fluid_port_2) <+ P(fluid_port_1,fluid_port_2)/R_hyd;
  end

end module
