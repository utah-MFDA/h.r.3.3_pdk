// Sophia Nielsen, sophi.nieslen@utah.edu
`include "nature_fluid_dynamics"
//`include "disciplines.vams"

// preset channel cross section

// (1) channel cross section for default channel (for easy manufacturing/3D printing)
// 8 layers tall, 14 pixels wide
// pixel size:  7.6 microns, layer size:  10  microns

// (2) channel cross section for smaller channels
// 5 layers tall, 6 pixels wide
// pixel size:  7.6 microns, layer size:  10  microns

module RectangularChannel (fl_in, fl_out, c_in, c_out);
  // input and output ports of channel
  // fluid_port_1 - input port for pressure and flow, conservative
  // fluid_port_2 - output port for pressure and flow, conservative
  //inout fluid_port_1, fluid_port_2;
  //input fluid_port_1;
  //output fluid_port_2;
  inout fl_in, fl_out, c_in, c_out;
  // declared  wiith fluidDynamics discipline
  fluidDynamics fl_in, fl_out;
  concentration c_in, c_out;
  //electrical fluid_port_1, fluid_port_2;
  //branch (fluid_port_1 fluid_port_2) branch1;

  // channel length (l - length (m))
  // fluid viscosity (nu - dynamic viscosity)
  // CROSS_SECTION - 1 for default channel, 2 for small channel
  parameter real L = 0.005, NU = 0.8891, CROSS_SECTION = 1;

  // initialize cross section variables: width in pixels, hieght in layers
  real width_pixels;
  real hieght_layers;

  real microns_per_pixel = 7.6;
  real microns_per_layer = 10;
  real meters_per_micron = 0.000001;

  real W;
  real H;

  real R_hyd;

  initial begin
    begin
    if (CROSS_SECTION == 1) begin
      width_pixels = 14;
      hieght_layers = 8;
    end
    else if(CROSS_SECTION == 2) begin
      width_pixels = 6;
      hieght_layers = 5;
    end
    end

    W = width_pixels*microns_per_pixel*meters_per_micron;
    H = hieght_layers*microns_per_layer*meters_per_micron;

    // Channel cross section (w - width, h - hieght),
    R_hyd = (12*NU*L)/(1 - 0.63*(H/W)) * 1/(H*H*H/W);
  end

  analog begin
    Q(fl_in,fl_out) <+ 1/R_hyd*P(fl_in,fl_out);
    //I(fluid_port_1,fluid_port_2) <+ V(fluid_port_1,fluid_port_2)/R_hyd;
    C(c_in,c_out) <+ C(c_in,c_out);
  end

  //analog
    //Q(fluid_port_1,fluid_port_2) <+ Q(fluid_port_1,fluid_port_2);

  //analog
    //P(fluid_port_1) <+ P(fluid_port_2);

endmodule
