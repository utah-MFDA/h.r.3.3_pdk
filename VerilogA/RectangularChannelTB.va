`include "RectangularChannel.va"
//`include "nature_fluid_dynamics"

module RectangularChannelTB;
  reg CLK = 0;
  //reg [10:0] QIN;
  //wire QOUT;
  input QIN;
  output QOUT;
  fluidDynamics QIN, QOUT;
  real qin;

  always begin
    #10 CLK = ~CLK;
  end

  initial begin
    qin = 1;
    $monitor("simtime = %g, CLK = %b, QIN = %b, QOUT  = %b", $time, CLK, QIN, QOUT);
  end

  analog
    Q(QIN) <+ qin;

  RectangularChannel ch1(.fluid_port_1(QIN), .fluid_port_2(QOUT));

endmodule // RectangularChannelTB
