//
// Pressure pump source
// Acts like a constant voltage source

`include "nature_fluid_dynamics.vams"

module PressurePump(fl_out, m_in, m_out);
//module PressurePump(out1, gnd, c_out, c_outg);

input m_in;
output fl_out, m_out;
fluidDynamics fl_out;
//concentration c_out;
massflow m_in, m_out;

// pressure of source
parameter real pressure=10;
//parameter real chem_concentration=100m;
//parameter real weight_concentration = 1.0;
parameter real mass_flow_in = 1.0;

//TODO implment ramprate for pump

analog begin
    P(fl_out) <+ pressure;
    //C(c_out) <+ chem_concentration;
    M(m_in, m_out) <+ mass_flow_in;
    //K(c_out)<+ 1;
end

endmodule
