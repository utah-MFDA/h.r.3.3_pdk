// Sophia Nielsen, sophi.nieslen@utah.edu
`include "nature_fluid_dynamics"

// serpentine
module SerpentineChannel (fluid_port_1,  fluid_port_2)
  // input and output ports of channel
  // fluid_port_1 - input port for pressure and flow, conservative
  // fluid_port_2 - output port for pressure and flow, conservative
  input fluid_port_1;
  output fluid_port_2;

  // FW - footprint width, defines square footprint of serpentine channel
  // B - number of bends in serpentine channel
  // fluid viscosity (nu - dynamic viscosity)
  // CROSS_SECTION - 1 for default channel, 2 for small channel
  parameter real FOOTPRINT_WIDTH;
  parameter real BENDS;
  parameter real NU;
  parameter real CROSS_SECTION;

  initial begin
    if(CROSS_SECTION == 1) {
      real width_pixels = 14;
      real hieght_layers = 8;
    }

    else if(CROSS_SECTION  == 2) {
      real width_pixels = 6;
      real hieght_layers = 5;
    }

    real microns_per_pixel = 7.6;
    real microns_per_layer = 10;
    real meters_per_micron = .000001;

    real W = width_pixels*microns_per_pixel*meters_per_micron;
    real H = hieght_layers*microns_per_layer*meters_per_micron;
    real L = BENDS*FOOTPRINT_WIDTH + FOOTPRINT_WIDTH;

    // Channel cross section (w - width, h - hieght),
    real R_hyd = (12*NU*L)/(1 - 0.63*(H/W)) * 1/(H*H*H/W);
  end

  analog begin
    Q(fluid_port_1,fluid_port_2) <+ P(fluid_port_1,fluid_port_2)/R_hyd;
  end

end module
