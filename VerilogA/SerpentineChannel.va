// Sophia Nielsen, sophi.nieslen@utah.edu
`include "nature_fluid_dynamics"

// serpentine
module SerpentineChannel (fl_in, fl_out, m_in, m_out);
  // input and output ports of channel
  // fluid_port_1 - input port for pressure and flow, conservative
  // fluid_port_2 - output port for pressure and flow, conservative
  input fl_in, m_in;
  output fl_out, m_out;
  fluidDynamics fl_in, fl_out;
  massflow m_in, m_out;

  // FW - footprint width, defines square footprint of serpentine channel
  // B - number of bends in serpentine channel
  // fluid viscosity (nu - dynamic viscosity)
  // CROSS_SECTION - 1 for default channel, 2 for small channel
  parameter real FOOTPRINT_WIDTH = 0.001064; // preset  for 5 BENDS
  parameter real NU = 0.0010016; // water at 20 deg C, [Pa s], [N s/m2]
  parameter real CROSS_SECTION = 1;

  // initialize cross section variables: width in pixels, hieght in layers
  real width_pixels;
  real hieght_layers;
  real channel_spacing;

  real microns_per_pixel = 7.6;
  real microns_per_layer = 10;
  real meters_per_micron = 0.000001;

  real channel_spacing_pixels = 14;

  real W;
  real H;
  real L;
  integer bends;
  real effective_footprint_width;

  real R_hyd;

  real weight_concentration_in;

  initial begin
    if(CROSS_SECTION == 1) begin
      width_pixels = 14;
      hieght_layers = 8;
    end

    else if(CROSS_SECTION  == 2) begin
      width_pixels = 6;
      hieght_layers = 5;
    end

    channel_spacing = channel_spacing_pixels*microns_per_pixel*meters_per_micron;

    W = width_pixels*microns_per_pixel*meters_per_micron;
    H = hieght_layers*microns_per_layer*meters_per_micron;

    bends = FOOTPRINT_WIDTH/(W+channel_spacing);
    //recalculate effective footprint width based on number of BENDS
    //there can be no partial BENDS

    effective_footprint_width = bends*(W+channel_spacing);

    L = bends*effective_footprint_width + effective_footprint_width;

    // Channel cross section (w - width, h - hieght),
    R_hyd = (12*NU*L)/(1 - 0.63*(H/W)) * 1/(H*H*H/W);
  end

  analog begin
    Q(fl_in,fl_out) <+ P(fl_in,fl_out)/R_hyd;
    //C(c_in)  <+ C(c_out);
    //M(m_out) <+ M(m_in);
  end

  assign m_out = ~m_in;

endmodule
