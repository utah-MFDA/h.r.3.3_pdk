//
// Syringe pump source
// Acts like a constant current source

`include "nature_fluid_dynamics"

module syringePump(out1, gnd);

output out1, gnd;
fluidDynamics out1, gnd;

// flow rate of syringe pump
parameter real flowrate = 1m;
parameter real rampRate = 1m;

ground gnd;
//TODO implment ramprate for pump

analog begin
    Q(out1) <+ flowrate;
end

endmodule
