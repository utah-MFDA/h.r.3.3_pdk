//
// Syringe pump source
// Acts like a constant current source

`include "nature_fluid_dynamics.vams"

module syringePump(fl_out, c_out);

output fl_out, c_out;
fluidDynamics fl_out;
concentration c_out;

// flow rate of syringe pump
parameter real flowrate = 1m;
parameter real rampRate = 1m;

parameter real chem_concentration = 100m;

//ground gnd, c_gnd;
//TODO implment ramprate for pump

analog begin
    Q(fl_out) <+ flowrate;
    C(c_out)  <+ chem_concentration;
end

endmodule
