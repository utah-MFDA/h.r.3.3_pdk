`include "nature_fluid_dynamics"

module MembraneValve(fl_port1,fl_port2,air_in);
input air_in, air_out;
inout fl_port1, fl_port2;
fluidDynamics fl_port1,fl_port2;

// Valve dimensional properties in pixels
parameter real dia=20, mem_th = 2;

// inlet and outlet channel properties
parameter real ch_h = 5, ch_w = 6, pn_h= 5, pn_w = 6;
// Total channel length into valve
parameter real L = 1.0m;

// Valve threshold for closing
parameter real theshold = 15; //PSI

// Standard pixel sizes
parameter real px_size = 7.6u, layer_h = 10u;

// standard 1
real H = 5, W = 6;
// standard 2
real H = 8, W = 14;

// Valve standard size 20px
real dia_m = px*dia;
real mem_th_m = px*mem_th;

// converts the channel size to meters
real Lm = L, Hm = H*layerm, Wm = W*px;

real R_valve = (12*nu*Lm)/(1 - 0.63*(Hm/Wm)) * 1/(Hm*Hm*Hm/Wm);

// ground delcaration
ground gnd;

// output
analog begin
    if (P(air_in,gnd) > theshold)
        Q(fl_port1, fl_port2) <+ P(fl_port1, fl_port2)/R_valve;
    else
        Q(fl_port1, fl_port2) <+ 0;
end

endmodule
