`include "nature_fluid_dynamics"

module MembraneValve(fl_port_1,
		     fl_port_2,
		     air_in,
		     air_out);

inout fl_port_1, fl_port_2;
input air_in;
output air_out;

//Define connections
branch (fl_port_1, fl_port_2) fl_res;
branch (air_in, air_out) a_res;

//input fl_port1; tried
//output fl_port2;

fluidDynamics fl_port_1,fl_port_2, air_in, air_out;
// tried declaring air port electrical

// Valve dimensional properties in pixels
parameter real dia=20, mem_th = 2;

parameter real nu = 0.8891m;

// inlet and outlet channel properties
// parameter real ch_h = 5, ch_w = 6, pn_h= 5, pn_w = 6;
// Total channel length into valve
parameter real L = 1.0m;

// Valve threshold for closing
parameter real theshold = 15; //PSI

// Standard pixel sizes
parameter real px_size = 7.6u, layer_h = 10u;
parameter real chan = 1;

/*
if(chan == 1)
    // standard 1
    real H = 5, W = 6;
else if (chan == 2)
    // standard 2
    real H = 8, W = 14;
*/
// validating test px size
parameter real H = 5, W = 6;

// Valve standard size 20px
real dia_m = px_size*dia;
real mem_th_m = layer_h*mem_th;

// converts the channel size from px/layer to meters
real Lm = L,
     Hm = H*layer_h,
     Wm = W*px_size;
real R_valve = (12*nu*Lm)/(1 - 0.63*(Hm/Wm)) * 1/(Hm*Hm*Hm/Wm);

//delay time
real del = 0.5; // sec

initial begin
$display("nu = %f, L = %f, H = %f, W = %f", nu, Lm, Hm, Wm);
$display("R = %f", R_valve);
end
// ground delcaration
//ground gnd;

// output
analog begin
    if (P(air_in, air_out) > theshold)
	//@(cross(P(air_in)) begin
        //Q(fl_port1, fl_port2) <+ P(fl_port1, fl_port2)/R_valve;
	// The idea is to have a pressure (voltage) transition during the cross event
	// with a delay of 0.5 sec. in rise time
	//X = transition(P(fl_port_1, fl_port_2), del);

	Q(fl_res) <+ P(fl_port_1, fl_port_2)/R_valve;
	//end
    else
	//@(cross(P(air_out)) begin
	// X = transition( 0, del);
	Q(fl_port_1, fl_port_2) <+ 0;
	//end
end

endmodule
