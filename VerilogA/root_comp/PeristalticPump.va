`include "nature_fluid_dynamics.vams"

module PumpValve(fl_in, fl_out, a_in);

//fl_in - input port for fluids
//fl_out- output port for fluid

inout fl_in, fl_out;
input a_in;
fluidDynamics fl_in, fl_out, a_in;

parameter real threshold = 103k; //Pa = 15 PSI

analog begin

    @(cross(threshold))

end

endmodule

module PeristalticPump(fl_in, fl_out, a_1, a_2, a_3);

input a_1, a_2, a_3;
inout fl_in, fl_out;
fluidDynamics fl_in, fl_out, a_1, a_2, a_3;
