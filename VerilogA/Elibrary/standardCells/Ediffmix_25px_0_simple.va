`include "disciplines.vams"
`include "constants.vams"

module diffmix_25px_0_fl(fl_i1, fl_i2, fl_out);

inout fl_i1, fl_i2, fl_out;

electrical fl_i1, fl_i2, fl_out;

electrical int_1;

(*desc="cross-section", type="instance"*)  parameter real CROSS_SECTION=1;
(*desc="viscosity", type="instance"*) parameter real NU = 0.001006;

real LENGTH1;
real LENGTH2;
real LENGTH3;

real R1_3;
real R2_3;
real R1, R2, R3;
real W, H, L1, L2, L3;
real ch_height_layers, ch_width_pixels;

real pixel_width;
real layer_height;

ground gnd;

//branch (fl_i1, int_1) int_br1;
//branch (fl_i2, int_1) int_br2;
//branch (fl_out,int_1) int_bro;

real fl_1, fl_2;

analog begin

   pixel_width = 7.6u;
   layer_height = 10u;

   LENGTH1=0.19m;
   LENGTH2=0.269m;
   LENGTH3=0.190m;

   begin
   if  (CROSS_SECTION == 1) begin
      ch_height_layers = 10;
      ch_width_pixels  = 14;
   end
   else if(CROSS_SECTION== 2) begin
      ch_height_layers = 5;
      ch_width_pixels  = 6;
   end
   end

   W  = ch_width_pixels * pixel_width;
   H  = ch_height_layers* layer_height;
   L1 = LENGTH1;
   L2 = LENGTH2;
   L3 = LENGTH3;

   R1 = (12*NU*L1) / (1 - 0.63*(H/W)) * 1/(H*H*H*W);
   R2 = (12*NU*L2) / (1 - 0.63*(H/W)) * 1/(H*H*H*W);
   R3 = (12*NU*L3) / (1 - 0.63*(H/W)) * 1/(H*H*H*W);

   $display(R1);
   $display(R2);
   $display(R3);

   //fl_1 = V(fl_i1, int_1)/R1;
   //fl_2 = V(fl_i2, int_1)/R2;

   //$display(fl_2);
   //$display(fl_1);

   R1_3 = R1 + R3;
   R2_3 = R2 + R3;

   //I(fl_i1, fl_out) <+ V(fl_i1, fl_out)/R1_3;
   //I(fl_i2, fl_out) <+ V(fl_i2, fl_out)/R2_3;
   //I(fl_out) <+  V(fl_i1, fl_out)/R1_3 + V(fl_i2, fl_out)/R2_3;
   //I(fl_out) <+  V(fl_i1, fl_out) + V(fl_i2, fl_out);

   I(fl_i1, int_1) <+ V(fl_i1, int_1)/R1;
   I(fl_i2, int_1) <+ V(fl_i2, int_1)/R2;

   I(int_1, fl_out)<+ V(int_1, fl_out)/R3;

end

endmodule
