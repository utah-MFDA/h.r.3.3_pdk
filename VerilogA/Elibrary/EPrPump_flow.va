//`include

module PressurePump(fl_out);//, c_out);

output fl_out;//, c_out;
electrical fl_out;//, c_out;

parameter real pressure=34k;
//parameter real chemConcentration=0;

analog begin
   V(fl_out) <+ pressure;
   //V(c_out)  <+ chemConcentration;
end

endmodule
