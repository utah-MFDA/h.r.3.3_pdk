//`include

module diffmix_25px_0(fl_i1, fl_i2, fl_out, c_i1, c_i2, c_out);

input fl_i1, fl_i2, c_i1, c_i2;
output c_i1, c_i2, c_out;

electrical fl_i1, fl_i2, fl_out, c_i1, c_i2, c_out;

//internal nodes
//output c_in1, c_in2;
electrical c_in1, c_in2;

parameter real CROSS_SECTION=1;
parameter real LENGTH1=0.19m, LENGTH2=0.269m, LENGTH3=0.190m;
parameter real NU = 0.001006;

real ch_height_layers, ch_width_pixels;

real pixel_width = 7.6u, layer_height = 10u;

real R1_3;
real R2_3;
real R1, R2, R3;
real W, H, L1, L2, L3;

initial begin
   begin
   if  (CROSS_SECTION == 1) begin
      ch_height_layers = 10;
      ch_width_pixels  = 14;
   end
   else if(CROSS_SECTION== 2) begin
      ch_height_layers = 5;
      ch_width_pixels  = 6;
   end
   end

W  = ch_width_pixels * pixel_width;
H  = ch_height_layers* layer_height;
L1 = LENGTH1;
L2 = LENGTH2;
L3 = LENGTH3;

R1 = (12*NU*L1) / (1 - 0.63*(H/W)) * 1/(H*H*H*W);
R2 = (12*NU*L2) / (1 - 0.63*(H/W)) * 1/(H*H*H*W);
R3 = (12*NU*L3) / (1 - 0.63*(H/W)) * 1/(H*H*H*W);

R1_3 = R1 + R3;
R2_3 = R2 + R3;

$display("resistance Mixer:");
$display(R1);
$display(R2);
$display(R3);

$display(" ");
$display(R1_3);
$display(R2_3);

end

analog begin
    I(fl_i1, fl_out) <+ V(fl_i1, fl_out)/R1_3;
    I(fl_i2, fl_out) <+ V(fl_i2, fl_out)/R2_3;
    //Concentration signals
    V(c_in1) <+ V(c_i1) * (V(fl_i1, fl_out)/R1_3) / (V(fl_i1, fl_out)/R1_3 + V(fl_i2, fl_out)/R2_3);
    V(c_in2) <+ V(c_i2) * (V(fl_i2, fl_out)/R2_3) / (V(fl_i1, fl_out)/R1_3 + V(fl_i2, fl_out)/R2_3);
    V(c_out) <+ V(c_in1) + V(c_in2);
end

endmodule

//`include

module serpentine_100px_0(fl_in, fl_out, c_in, c_out);

parameter real length=3.8m, CROSS_SECTION=1, NU=0.0010016;

real pixel_size = 7.6u, layer_height = 10u;
real W, H, L;
real R;
real ch_width_pixels, ch_height_layers;

initial begin
   begin
   if (CROSS_SECTION == 1) begin
      ch_width_pixels = 14;
      ch_height_layers= 10;
   end
   else if(CROSS_SECTION == 2) begin
      ch_width_pixels = 6;
      ch_height_layers= 5;
   end
   end

   W = pixel_size * ch_width_pixels;
   H = layer_height*ch_height_layers;
   L = length;

   R = (12*NU*L) / (1 - 0.63*(H/W)) * 1/(H*H*H*W);
   $display("resistance:");
   $display(R);
end

analog begin
    I(fl_in, fl_out) <+ V(fl_in, fl_out)/R;
    V(c_out) <+ V(c_in);
end

endmodule

//`include

module serpentine_150px_0(fl_in, fl_out, c_in, c_out);

parameter real length=7.980m, CROSS_SECTION=1, NU=0.0010016;

real pixel_size = 7.6u, layer_height = 10u;
real W, H, L;
real R;
real ch_width_pixels, ch_height_layers;

initial begin
   begin
   if (CROSS_SECTION == 1) begin
      ch_width_pixels = 14;
      ch_height_layers= 10;
   end
   else if(CROSS_SECTION == 2) begin
      ch_width_pixels = 6;
      ch_height_layers= 5;
   end
   end

   W = pixel_size * ch_width_pixels;
   H = layer_height*ch_height_layers;
   L = length;

   R = (12*NU*L) / (1 - 0.63*(H/W)) * 1/(H*H*H*W);
   $display("resistance:");
   $display(R);
end

analog begin
    I(fl_in, fl_out) <+ V(fl_in, fl_out)/R;
    V(c_out) <+ V(c_in);
end

endmodule

//`include

module serpentine_200px_0(fl_in, fl_out, c_in, c_out);

parameter real length=13.680m, CROSS_SECTION=1, NU=0.0010016;

real pixel_size = 7.6u, layer_height = 10u;
real W, H, L;
real R;
real ch_width_pixels, ch_height_layers;

initial begin
   begin
   if (CROSS_SECTION == 1) begin
      ch_width_pixels = 14;
      ch_height_layers= 10;
   end
   else if(CROSS_SECTION == 2) begin
      ch_width_pixels = 6;
      ch_height_layers= 5;
   end
   end

   W = pixel_size * ch_width_pixels;
   H = layer_height*ch_height_layers;
   L = length;

   R = (12*NU*L) / (1 - 0.63*(H/W)) * 1/(H*H*H*W);
   $display("resistance:");
   $display(R);
end

analog begin
    I(fl_in, fl_out) <+ V(fl_in, fl_out)/R;
    V(c_out) <+ V(c_in);
end

endmodule

//`include

module serpentine_25px_0(fl_in, fl_out, c_in, c_out);

parameter real length=0.380m, CROSS_SECTION=1, NU=0.0010016;

real pixel_size = 7.6u, layer_height = 10u;
real W, H, L;
real R;
real ch_width_pixels, ch_height_layers;

initial begin
   begin
   if (CROSS_SECTION == 1) begin
      ch_width_pixels = 14;
      ch_height_layers= 10;
   end
   else if(CROSS_SECTION == 2) begin
      ch_width_pixels = 6;
      ch_height_layers= 5;
   end
   end

   W = pixel_size * ch_width_pixels;
   H = layer_height*ch_height_layers;
   L = length;

   R = (12*NU*L) / (1 - 0.63*(H/W)) * 1/(H*H*H*W);
   $display("resistance:");
   $display(R);
end

analog begin
    I(fl_in, fl_out) <+ V(fl_in, fl_out)/R;
    V(c_out) <+ V(c_in);
end

endmodule

//`include

module serpentine_300px_0(fl_in, fl_out, c_in, c_out);

parameter real length=29.640m, CROSS_SECTION=1, NU=0.0010016;

real pixel_size = 7.6u, layer_height = 10u;
real W, H, L;
real R;
real ch_width_pixels, ch_height_layers;

initial begin
   begin
   if (CROSS_SECTION == 1) begin
      ch_width_pixels = 14;
      ch_height_layers= 10;
   end
   else if(CROSS_SECTION == 2) begin
      ch_width_pixels = 6;
      ch_height_layers= 5;
   end
   end

   W = pixel_size * ch_width_pixels;
   H = layer_height*ch_height_layers;
   L = length;

   R = (12*NU*L) / (1 - 0.63*(H/W)) * 1/(H*H*H*W);
   $display("resistance:");
   $display(R);
end

analog begin
    I(fl_in, fl_out) <+ V(fl_in, fl_out)/R;
    V(c_out) <+ V(c_in);
end

endmodule

//`include

module serpentine_300px_1(fl_in, fl_out, c_in, c_out);

parameter real length=59.280m, CROSS_SECTION=1, NU=0.0010016;

real pixel_size = 7.6u, layer_height = 10u;
real W, H, L;
real R;
real ch_width_pixels, ch_height_layers;

initial begin
   begin
   if (CROSS_SECTION == 1) begin
      ch_width_pixels = 14;
      ch_height_layers= 10;
   end
   else if(CROSS_SECTION == 2) begin
      ch_width_pixels = 6;
      ch_height_layers= 5;
   end
   end

   W = pixel_size * ch_width_pixels;
   H = layer_height*ch_height_layers;
   L = length;

   R = (12*NU*L) / (1 - 0.63*(H/W)) * 1/(H*H*H*W);
   $display("resistance:");
   $display(R);
end

analog begin
    I(fl_in, fl_out) <+ V(fl_in, fl_out)/R;
    V(c_out) <+ V(c_in);
end

endmodule

//`include

module serpentine_300px_2(fl_in, fl_out, c_in, c_out);

parameter real length=88.920m, CROSS_SECTION=1, NU=0.0010016;

real pixel_size = 7.6u, layer_height = 10u;
real W, H, L;
real R;
real ch_width_pixels, ch_height_layers;

initial begin
   begin
   if (CROSS_SECTION == 1) begin
      ch_width_pixels = 14;
      ch_height_layers= 10;
   end
   else if(CROSS_SECTION == 2) begin
      ch_width_pixels = 6;
      ch_height_layers= 5;
   end
   end

   W = pixel_size * ch_width_pixels;
   H = layer_height*ch_height_layers;
   L = length;

   R = (12*NU*L) / (1 - 0.63*(H/W)) * 1/(H*H*H*W);
   $display("resistance:");
   $display(R);
end

analog begin
    I(fl_in, fl_out) <+ V(fl_in, fl_out)/R;
    V(c_out) <+ V(c_in);
end

endmodule

//`include

module serpentine_50px_0(fl_in, fl_out, c_in, c_out);

parameter real length=1.140m, CROSS_SECTION=1, NU=0.0010016;

real pixel_size = 7.6u, layer_height = 10u;
real W, H, L;
real R;
real ch_width_pixels, ch_height_layers;

initial begin
   begin
   if (CROSS_SECTION == 1) begin
      ch_width_pixels = 14;
      ch_height_layers= 10;
   end
   else if(CROSS_SECTION == 2) begin
      ch_width_pixels = 6;
      ch_height_layers= 5;
   end
   end

   W = pixel_size * ch_width_pixels;
   H = layer_height*ch_height_layers;
   L = length;

   R = (12*NU*L) / (1 - 0.63*(H/W)) * 1/(H*H*H*W);
   $display("resistance:");
   $display(R);
end

analog begin
    I(fl_in, fl_out) <+ V(fl_in, fl_out)/R;
    V(c_out) <+ V(c_in);
end

endmodule

//`include

module serpentine_75px_0(fl_in, fl_out, c_in, c_out);

parameter real length=2.280m, CROSS_SECTION=1, NU=0.0010016;

real pixel_size = 7.6u, layer_height = 10u;
real W, H, L;
real R;
real ch_width_pixels, ch_height_layers;

initial begin
   begin
   if (CROSS_SECTION == 1) begin
      ch_width_pixels = 14;
      ch_height_layers= 10;
   end
   else if(CROSS_SECTION == 2) begin
      ch_width_pixels = 6;
      ch_height_layers= 5;
   end
   end

   W = pixel_size * ch_width_pixels;
   H = layer_height*ch_height_layers;
   L = length;

   R = (12*NU*L) / (1 - 0.63*(H/W)) * 1/(H*H*H*W);
   $display("resistance:");
   $display(R);
end

analog begin
    I(fl_in, fl_out) <+ V(fl_in, fl_out)/R;
    V(c_out) <+ V(c_in);
end

endmodule

module valve_20px_1();

endmodule

module Channel(fl_in, fl_out, c_in, c_out);

inout fl_in, fl_out, c_in, c_out;
electrical fl_in, fl_out, c_in, c_out;

// vector test
parameter integer vec_size = 1;

inout [0:vec_size-1] c_in;
inout [0:vec_size-1] c_out;

parameter real length=5m, CROSS_SECTION=1, NU=0.0010016;

real pixel_size = 7.6u, layer_height = 10u;
real W, H, L;
real R;
real ch_width_pixels, ch_height_layers;

integer i;

//inout [vec_size:0] c_in;

initial begin
   begin
   if (CROSS_SECTION == 1) begin
      ch_width_pixels = 14;
      ch_height_layers= 10;
   end
   else if(CROSS_SECTION == 2) begin
      ch_width_pixels = 6;
      ch_height_layers= 5;
   end
   else if(CROSS_SECTION == 3) begin
      ch_width_pixels = 28;
      ch_height_layers= 20;
   end
   else if(CROSS_SECTION == 4) begin
      ch_width_pixels = 42;
      ch_height_layers= 30;
   end
   else if(CROSS_SECTION == 5) begin
      ch_width_pixels = 70;
      ch_height_layers= 50;
   end
   end

   W = pixel_size * ch_width_pixels;
   H = layer_height*ch_height_layers;
   L = length;

   R = (12*NU*L) / (1 - 0.63*(H/W)) * 1/(H*H*H*W);
   $display("resistance:");
   $display(R);
end

analog begin
   I(fl_in, fl_out) <+ V(fl_in, fl_out)/R;
   for (i = vec_size-1; i >= 0; i = i - 1) begin
      V(c_out[i]) <+ V(c_in[i]);
   end // end FOR LOOP
   //V(c_out) <+ V(c_in);
end

endmodule

module EValve(fl_in, fl_out, c_in, c_out, pn_in, pn_out);

inout fl_in, fl_out;
inout c_in, c_out;
inout pn_in, pn_out;

electrical fl_in, fl_out, c_in, c_out, pn_in, pn_out;

parameter real valve_diameter_px=200;
parameter real L = 0.1;
parameter real CROSS_SECTION = 1, nu=0.0010016;;
parameter real mem_th = 2;

real pixel_size = 7.6u, layer_height = 10u;

real threshold_pressure_PSI = 15;

real H_layer, W_px;
real Hm, Wm, Lm;
real dia_m, mem_th_m;
real R_valve;

initial begin
    begin
    if (CROSS_SECTION == 1) begin
        // standard 1
        H_layer = 5;
        W_px = 6;
    end
    else if (CROSS_SECTION == 2) begin
        // standard 2
        H_layer = 8;
        W_px = 14;
    end
    end

    // Valve standard size 20px
    dia_m = pixel_size*valve_diameter_px;
    mem_th_m = pixel_size*mem_th;

    // converts the channel size to meters
    Lm = L;
    Hm = H_layer*layer_height;
    Wm = W_px*pixel_size;

    R_valve = (12*nu*Lm)/(1 - 0.63*(Hm/Wm)) * 1/(Hm*Hm*Hm/Wm);

end

analog begin
    if (V(pn_in) >= threshold_pressure_PSI)
        I(fl_in, fl_out) <+ V(fl_in, fl_out)/R_valve;
    else
        I(fl_in, fl_out) <+ 0;

    V(c_out) <+ V(c_in);
end

endmodule

module PneumaticSwitch(pn_out);

output pn_out;
electrical pn_out;

parameter real period = 1.0, start = 0;
parameter real input_pressure = 15;

real output_v = 0;

analog begin
    @(timer(start))
        output_v = input_pressure;
    @(timer(start+period))
        output_v = 0;
    V(pn_out) <+ transition(output_v, 0.0);
end

endmodule

module PressurePump(fl_out, c_out);

// vector test
parameter integer vec_size = 1;

output fl_out;
output [0:vec_size-1] c_out;

electrical fl_out, c_out;

parameter real pressure=34k;
parameter real chemConcentration=0;

integer i;

analog begin
   V(fl_out) <+ pressure;
   for (i = vec_size-1; i >= 0; i = i - 1) begin
      V(c_out[i])  <+ chemConcentration;
   end // end FOR LOOP

end

endmodule
