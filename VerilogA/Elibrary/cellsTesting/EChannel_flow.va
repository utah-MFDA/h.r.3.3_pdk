//`include

module Channel(fl_in, fl_out);//, c_in, c_out);

inout fl_in, fl_out;//, c_in, c_out;
electrical fl_in, fl_out;//, c_in, c_out;

parameter real length=5m, CROSS_SECTION=1, NU=0.0010016;

real pixel_size = 7.6u, layer_height = 10u;
real W, H, L;
real R_h;
real ch_width_pixels, ch_height_layers;

initial begin
   begin
   if (CROSS_SECTION == 1) begin
      ch_width_pixels = 14;
      ch_height_layers= 10;
   end
   else if(CROSS_SECTION == 2) begin
      ch_width_pixels = 6;
      ch_height_layers= 5;
   end
   end

   W = pixel_size * ch_width_pixels;
   H = layer_height*ch_height_layers;
   L = length;

   R_h = (12*NU*L) / (1 - 0.63*(H/W)) * 1/(H*H*H*W);
   $display("resistance:");
   $display(R_h);
end

analog begin
    I(fl_in, fl_out) <+ V(fl_in, fl_out)/R_h;
    //V(c_out) <+ V(c_in);
end

endmodule
