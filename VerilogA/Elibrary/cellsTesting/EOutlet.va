//`include

module Outlet(fl_in, c_in);

endmodule
