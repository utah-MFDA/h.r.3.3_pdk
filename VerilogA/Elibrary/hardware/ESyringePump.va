`include "disciplines.vams"
`include "constants.vams"

module ESyringePump(fl_out, c_out);

output fl_out;
output c_out;

electrical fl_out, c_out;

(*desc="input-flow", type="instance"*) parameter real fluidflow=34;
(*desc="input chemical concentration", type="instance"*) parameter real chemConcentration=0;

//integer i;

analog begin
   I(fl_out) <+ fluidflow;
   V(c_out)  <+ chemConcentration;
   //for (i = vec_size-1; i >= 0; i = i - 1) begin
   //   V(c_out[i])  <+ chemConcentration;
   //end // end FOR LOOP

end

endmodule
