module PneumaticSwitch(pn_out);

output pn_out;
electrical pn_out;

parameter real period = 1.0, start = 0;
parameter real input_pressure = 15;

real output_v = 0;

analog begin
    @(timer(start))
        output_v = input_pressure;
    @(timer(start+period))
        output_v = 0;
    V(pn_out) <+ transition(output_v, 0.0);
end

endmodule
