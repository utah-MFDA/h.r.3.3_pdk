'include nature_fluid_dynamics

module CirValve(p,n,g);

parameter real ch_h, pn_h, dia, mem_th;
fluidDynamics p,n

endmodule
