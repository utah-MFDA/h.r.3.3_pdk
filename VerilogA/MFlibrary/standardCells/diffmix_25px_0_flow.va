`include "nature_fluid_dynamics.vams"
`include "disciplines.vams"
`include "constants.vams"

module diffmix_25px_0_fl(fl_i1, fl_i2, fl_out);

inout fl_i1, fl_i2, fl_out;

fluidDynamics fl_i1, fl_i2, fl_out;

fluidDynamics int_1;

(*desc="cross-section", type="instance"*)  parameter real CROSS_SECTION=1;
(*desc="viscosity", type="instance"*) parameter real NU = 0.001006;

real LENGTH1;
real LENGTH2;
real LENGTH3;

real R1_3;
real R2_3;
real R1, R2, R3;
real W, H, L1, L2, L3;
real ch_height_layers, ch_width_pixels;

real pixel_width;
real layer_height;

ground gnd;

analog begin

   pixel_width = 7.6u;
   layer_height = 10u;

   LENGTH1=0.19m;
   LENGTH2=0.269m;
   LENGTH3=0.190m;

   begin
   if  (CROSS_SECTION == 1) begin
      ch_height_layers = 10;
      ch_width_pixels  = 14;
   end
   else if(CROSS_SECTION== 2) begin
      ch_height_layers = 5;
      ch_width_pixels  = 6;
   end
   end

   W  = ch_width_pixels * pixel_width;
   H  = ch_height_layers* layer_height;
   L1 = LENGTH1;
   L2 = LENGTH2;
   L3 = LENGTH3;

   R1 = (12*NU*L1) / (1 - 0.63*(H/W)) * 1/(H*H*H*W);
   R2 = (12*NU*L2) / (1 - 0.63*(H/W)) * 1/(H*H*H*W);
   R3 = (12*NU*L3) / (1 - 0.63*(H/W)) * 1/(H*H*H*W);

   R1_3 = R1 + R3;
   R2_3 = R2 + R3;

   // branch flow calculation
   Q(fl_i1, int_1) <+ P(fl_i1, int_1)/R1;
   Q(fl_i2, int_1) <+ P(fl_i2, int_1)/R2;

   Q(int_1, fl_out)<+ P(int_1, fl_out)/R3;

end

endmodule
