`include "nature_fluid_dynamics.vams"

module OutletPort (fl_in, c_in);

  input fl_in, c_in;

  fluidDynamics fl_in;
  concentration c_in;

  analog begin
    P(fl_in) <+ gnd;
    K(c_in) <+ gnd;
  end
endmodule
