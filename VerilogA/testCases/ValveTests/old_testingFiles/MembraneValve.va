`include "./../../nature_fluid_dynamics"
//`include "disciplines.vams"

module MembraneValve(fl_port1,fl_port2,air_in, air_o);
// pneumatic diffinitions
input air_in;
output air_o;

// fluid port difinitions
inout fl_port1;
inout fl_port2;
fluidDynamics fl_port1, fl_port2, air_in, air_o;

// channel parameters
parameter real ch_h = 0.05, pn_h=0.05, dia=0.2, mem_th = 0.02;
// Valve thereshold parameters
parameter real theshold = 15; //PSI
//fluidDynamics fl_port1,fl_port2;
//electrical fl_port1, fl_port2;
parameter real H = 0.1, W = 0.1, L=0.5, nu=0.8891m;

real R_valve = (12*nu*L)/(1 - 0.63*(H/W)) * 1/(H*H*H/W);

// testing diplay
initial begin
    $display("R = %f", R_valve);
end

// output
analog begin
    if (P(air_in, air_o) > theshold)
        Q(fl_port1, fl_port2) <+ P(fl_port1, fl_port2)/R_valve;
    else
        Q(fl_port1, fl_port2) <+ 0;
end

endmodule
