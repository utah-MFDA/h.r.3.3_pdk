//`include "nature_fluid_dynamics.vams"
`include "disciplines.vams"
`include "constants.vams"

//Capacitor
//
// based on scaling R with repect to chamber h
//

module membrane_cap_20pxV_nlin_5_1(p, n);
  electrical p, n;

  inout p, n;

  ////
  // these variables are used for small deflections

  // typical dimension for a 3D printed valve
  (*desc="membrane thickness", type="instance"*) parameter real mem_th = 20u;

  // properties of PEGDA with 2% NPS
  (*desc="Young's modulus", type="instance"*) parameter real mem_Emod = 7.7e6; // MPa

  // estimating poisson's ratio using a typical value for epoxies
  //   which tend to be 0.3 - 0.35
  (*desc="Poisson's ratio", type="instance"*) parameter real mem_v = 0.3;

  // membrane radius
  (*desc="membrane radius", type="instance"*) parameter real mem_r = 100u; // meters

  ////
  // these are used for large deflections
  // these variables derive from the Karman's large circular plate deflections

  (*desc="fluid chamber height", type="instance"*) parameter real fl_ch_h = 20u; // meters
  (*desc="pneumatic chamber height", type="instance"*) parameter real pn_ch_h = 100u; // meters

  branch (p, n) q_cap ;
  real p_c;

  real D;
  real R;
  real w0_v;
  real cap;
  real vol_rd;
  real vol_int;

  real c1;
  real c2;
  real c_dp2;

  real dp2_0;
  real d2v_dp2;

  real r_diff;
  real R_dp20;
  real p_c_dp20;
  real lin_cap;

  real c_11, c_21;
  real c_rdp2_1, c_rdp2_2;

  (*desc="valve Resistance", type="instance"*) parameter real C_res = 0;
  (*desc="viscosity", type="instance"*) parameter real nu = 0.0010016;

  analog
  begin

    // circuilar membrane
    D = mem_Emod*pow(mem_th, 3)/(12*(1-mem_v*mem_v)) ;

    // deflection at center
    w0_v = fl_ch_h*64*D/(pow(mem_r,4)) ;

    //linear capacitance
    cap = 3.141*pow(mem_r, 6)/(16*mem_Emod*pow(mem_th,3)) * (1 - mem_v*mem_v) ;

    c_11 = fl_ch_h*64*D;
    c_21 = fl_ch_h*D;

    c1 =  3.141*fl_ch_h*mem_r/2 * pow(c_11, 0.25);
    c2 = -3.141*(1-pow(mem_v,2))/(mem_Emod*pow(mem_th, 3)) * 16*pow(c_21, 1.5) - \
      3.141*fl_ch_h/2 * pow(c_11, 0.5);

    //d2v_dp2 =
    R = pow(c_11, 0.25) * pow(abs(V(q_cap)), -0.25);

    c_dp2   = c2*(-3/2)/(c1*(-5/4));
    dp2_0   = pow(c_dp2, 4);

    begin
    if (abs(V(q_cap)) < dp2_0) begin

      //constant for delta
      c_rdp2_1 = fl_ch_h*64*D/dp2_0;
      R_dp20   = pow(c_rdp2_1, 0.25);

      // delta of radii
      c_rdp2_2 = mem_r-R_dp20;
      p_c_dp20 = 3.141*(1-mem_v*mem_v)/(16*mem_Emod*pow(mem_th,3))*pow(R_dp20,6)*dp2_0 + \
        3.141*fl_ch_h*pow(c_rdp2_2, 2);
      lin_cap = p_c_dp20/dp2_0;

      p_c = lin_cap*V(q_cap) ;
    end
    else if (V(q_cap)>0) begin
      // delta of radii
      r_diff = mem_r - R;
      p_c = 3.141*(1-mem_v*mem_v)/(16*mem_Emod*pow(mem_th,3))*pow(R,6)*abs(V(q_cap)) +\
        3.141*fl_ch_h*pow(r_diff, 2);
    end
    else if (V(q_cap)<0) begin
      // delta of radii
      r_diff = mem_r - R;
      p_c = -3.141*(1-mem_v*mem_v)/(16*mem_Emod*pow(mem_th,3))*pow(R,6)*abs(V(q_cap)) -\
        3.141*fl_ch_h*pow(r_diff, 2);

    end
    end

    I(q_cap) <+ ddt(p_c) ;

 end
endmodule
