`include "disciplines.vams"
`include "constants.vams"

module channel2(fl_i, fl_o);
  electrical fl_i, fl_o;
  inout fl_i, fl_o;

  (*desc="ChannelW", type="instance"*) parameter real w=100u;
  (*desc="ChannelH", type="instance"*) parameter real h=100u;

  (*desc="ChannelL", type="instance"*) parameter real L=2m;

  real R;

  analog begin
    R = L * 1/(w*h*h*h);
    I(fl_i, fl_o) <+ V(fl_i, fl_o)/R;

  end
endmodule
