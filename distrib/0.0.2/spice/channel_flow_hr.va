`include "nature_fluid_dynamics.vams"
`include "disciplines.vams"
`include "constants.vams"

module channel_flow_hr(fl_in, fl_out) ;

inout fl_in, fl_out;
fluidDynamics fl_in, fl_out;
branch (fl_in, fl_out) fl_br ;

(*desc="length", type="instance"*) parameter real length=5m;
(*desc="cross-section", type="instance"*) parameter real crosssection=1;
(*desc="viscosity", type="instance"*) parameter real nu=0.0010016;

real pixel_size;
real layer_height;
real W, H, L;
real R;
real ch_width_pixels;
real ch_height_layers;

analog begin

   //@(initial_instance)
   begin : initial_instance
      pixel_size = 7.6u;
      layer_height = 10u;

      begin
      if (1 - crosssection <= 1e-4) begin
         ch_width_pixels = 14;
         ch_height_layers= 10;
      end
      else if(2 - crosssection <= 1e-4) begin
         ch_width_pixels = 6;
         ch_height_layers= 5;
      end
      else if(3 - crosssection <= 1e-4) begin
         ch_width_pixels = 28;
         ch_height_layers= 20;
      end
      else if(4 - crosssection <= 1e-4) begin
         ch_width_pixels = 42;
         ch_height_layers= 30;
      end
      else if(crosssection <= 1e-4) begin
         ch_width_pixels = 70;
         ch_height_layers= 50;
      end
      end

      W = pixel_size * ch_width_pixels;
      H = layer_height*ch_height_layers;
      L = length;

      R = (12*nu*L) / (1 - 0.63*(H/W)) * 1/(H*H*H*W);
   end

   Qfl(fl_br) <+ P(fl_br)/R;

end

endmodule
