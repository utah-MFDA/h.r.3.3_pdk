`include "nature_fluid_dynamics.vams"
`include "disciplines.vams"
`include "constants.vams"

module syringePump(fl_out, c_out);

output fl_out;
output c_out;

fluidDynamics fl_out;
concentration c_out;

(*desc="input-flow", type="instance"*) parameter real fluidflow=34;
(*desc="input chemical concentration", type="instance"*) parameter real chemConcentration=0;

//integer i;

fluidDynamics gnd_fl ;
ground gnd_fl ;

concentration gnd_c ;
ground gnd_c ;

analog begin
   Qfl(fl_out, gnd_fl) <+ fluidflow;
   C(c_out, gnd_c)  <+ chemConcentration;
   //for (i = vec_size-1; i >= 0; i = i - 1) begin
   //   V(c_out[i])  <+ chemConcentration;
   //end // end FOR LOOP

end

endmodule
