* p_resistor 0 subcir

.SUBCKT p_resistor_0 11 13 80 82 PARAMS: numblocks=1 wchan=14 hchan=10 w3chan=6 h3chan=5 lenchan=5 pixel_size=7.6u

Ychannel c1 11 12 80 81 length={(2*numblocks+1)*wchan*pixel_size} chan_w=lenchan*pixel_size chan_h=hchan*pixel_size
Ychannel c0 12 13 81 82 length={(2*numblocks)*lenchan*pixel_size} chan_w=w3chan*pixel_size chan_h=h3chan*pixel_size

.ENDS
