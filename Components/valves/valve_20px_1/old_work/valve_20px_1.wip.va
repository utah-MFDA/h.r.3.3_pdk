//`include "nature_fluid_dynamics.vams"
`include "nature_fluid_dynamics.vams"
`include "disciplines.vams"
`include "constants.vams"

module valve_20px_1(fl_in, fl_out,  pn_in, pn_out);
//module valve_20px_1(fl_in, fl_out,  pn_in, pn_out, c_in, c_out);
//c_in, c_out,

inout fl_in;
inout fl_out;
//inout c_in;
//inout c_out;
inout pn_in;
inout pn_out;

fluidDynamics fl_in, fl_out;
fluidDynamics fl_m;
fluidDynamics pn_in, pn_out;

//concentration c_in, c_out;
//concentration cv1, cv2;
//branch (c_in, c_out) chem;

(*desc="valve-diameter", type="instance"*) parameter real valve_diameter_px=200;
(*desc="length", type="instance"*)         parameter real L_mm = 6e-3;
(*desc="cross-section", type="instance"*)  parameter real CROSS_SECTION = 2;
(*desc="viscosity", type="instance"*)      parameter real NU=0.0010016;
//(*desc="membrane-thickness", type="instance"*)  parameter real mem_th = 2;

(*desc="threshold_pressure", type="instance"*) parameter real threshold_pressure_kPa=103e3;
(*desc="threshold_pressure", type="instance"*) parameter real transition_pressure_kPa=6.8e3;

(*desc="pn viscosity (usually air)", type="instance"*)   parameter real nu_pn=18.03e-6;
(*desc="pn length", type="instance"*)         parameter real L_pn = 6e-3;
(*desc="pn cross-section", type="instance"*)  parameter real CROSS_SECTION_PN = 2;

real pixel_size ;
real layer_height ;

real H_layer ;
real W_px ;
real H_layer_pn ;
real W_px_pn ;

real R_valve ; // resistance of valve

real P_lin, P_lin_start;

(*desc="capacitance concentration", type="instance"*) parameter real ccap=100u ;

//real cqi, cqo;
ground gnd;

// membrane definitions
// typical dimension for a 3D printed valve
(*desc="membrane thickness", type="instance"*) parameter real mem_th = 20u;

// properties of PEGDA with 2% NPS
(*desc="Young's modulus", type="instance"*) parameter real mem_Emod = 7.7; // MPa

// estimating poisson's ratio using a typical value for epoxies
//   which tend to be 0.3 - 0.35
(*desc="Poisson's ratio", type="instance"*) parameter real mem_v = 0.3;

(*desc="fluid chamber height", type="instance"*) parameter real fl_ch_h = 20u; // meters
(*desc="pneumatic chamber height", type="instance"*) parameter real pn_ch_h = 100u; // meters

//branch (fl_m, pn_m) q_cap ;

branch (fl_in, fl_m) fl_ib;
branch (fl_m, fl_out) fl_ob;

analog begin

  @(initial_instance)
  begin : initial_instance
    pixel_size = 7.6u;
    layer_height = 10u;

    begin
    if (CROSS_SECTION == 1) begin
        // standard 1
        H_layer = 5;
        W_px = 6;
    end
    else if (CROSS_SECTION == 2) begin
        // standard 2
        H_layer = 8;
        W_px = 14;
    end
    end

    begin
    if (CROSS_SECTION_PN == 1) begin
        // standard 1
        H_layer_pn = 5;
        W_px_pn    = 6;
    end
    else if (CROSS_SECTION_PN == 2) begin
        // standard 2
        H_layer_pn = 8;
        W_px_pn    = 14;
    end
    end

    P_lin = transition_pressure_kPa ;
    //P_lin = 0.5*transition_pressure_kPa ;
    P_lin_start = threshold_pressure_kPa - P_lin;

    R_valve = \
      (12*NU*L_mm) / (1 - 0.63*(H_layer/W_px)) * 1/(H_layer*H_layer*H_layer*W_px);
  end

    // switch ----------------
    if (P(pn_in) > threshold_pressure_kPa) begin
        // Pressure above theshold
        // closed valve
        Qfl(fl_ib) <+ 0;

    end else if (threshold_pressure_kPa - P(pn_in) <= P_lin) begin
        // linear region to bridge on-off
        Qfl(fl_ib) <+ P(fl_ib)/R_valve - \
            P(fl_ib)/R_valve * \
              ((P(pn_in)-P_lin_start)/(threshold_pressure_kPa-P_lin_start));

    end else begin
        // open valve
        Qfl(fl_ib) <+ P(fl_ib)/R_valve;
    end

    //cqi = ccap*C(c_in,  cv1) ;
    //cqo = ccap*C(c_out, cv2);
    //Ci(c_in,  cv1) <+ ddt(cqi) ;
    //Ci(c_out, cv2) <+ ddt(cqo) ;
    //C(cv1, cv2) <+ 0 ;

end // end analog

endmodule
