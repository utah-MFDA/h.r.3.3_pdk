`include "nature_fluid_dynamics.vams"
`include "disciplines.vams"
`include "constants.vams"

module valve_20px_1(fl_in, fl_out, c_in, c_out, pn_in, pn_out);

inout fl_in, fl_out;
inout c_in, c_out;
inout pn_in, pn_out;

fluidDynamics fl_in, fl_out;
concentration c_in, c_out;
fluidDynamics pn_in, pn_out;

(*desc="valve-diameter", type="instance"*) parameter real valve_diameter_px=200;
(*desc="length", type="instance"*)         parameter real L = 0.1;
(*desc="cross-section", type="instance"*)  parameter real CROSS_SECTION = 1;
(*desc="viscosity", type="instance"*)      parameter real nu=0.0010016;
(*desc="membrane-thickness", type="instance"*)  parameter real mem_th = 2;

real pixel_size;
real layer_height;
real threshold_pressure_PSI;

real H_layer, W_px;
real Hm, Wm, Lm;
real dia_m, mem_th_m;
real R_valve;

analog begin

    pixel_size = 7.6u;
    layer_height = 10u;

    threshold_pressure_PSI = 15;

    begin
    if (CROSS_SECTION == 1) begin
        // standard 1
        H_layer = 5;
        W_px = 6;
    end
    else if (CROSS_SECTION == 2) begin
        // standard 2
        H_layer = 8;
        W_px = 14;
    end
    end

    // Valve standard size 20px
    dia_m = pixel_size*valve_diameter_px;
    mem_th_m = pixel_size*mem_th;

    // converts the channel size to meters
    Lm = L;
    Hm = H_layer*layer_height;
    Wm = W_px*pixel_size;

    R_valve = (12*nu*Lm)/(1 - 0.63*(Hm/Wm)) * 1/(Hm*Hm*Hm/Wm);

    begin
    if (P(pn_in) >= threshold_pressure_PSI)
        Q_r = P(fl_in, fl_out)/R_valve;
        Q(fl_in, fl_out) <+ Q_r + transition(Q_r, 0, 200m, 200m);
    end
    else
        Q(fl_in, fl_out) <+ 0 + transition(-Q_r, 0, 200m, 200m);
    end
    end

    C(c_out) <+ C(c_in);
end // end analog

endmodule
