//`include "nature_fluid_dynamics.vams"
`include "disciplines.vams"
`include "constants.vams"

module valve_fl_20px_1_V1(fl_in, fl_out,  pn_in);
//c_in, c_out,

inout fl_in, fl_out;
//inout c_in, c_out;
inout pn_in;//, pn_out;

electrical fl_in, fl_out;
electrical fl_m;
electrical pn_m;
electrical pn_in;//, pn_out;

(*desc="valve-diameter", type="instance"*) parameter real valve_diameter_px=200;
(*desc="length", type="instance"*)         parameter real L = 6e-3;
(*desc="cross-section", type="instance"*)  parameter real CROSS_SECTION = 2;
(*desc="viscosity", type="instance"*)      parameter real nu=0.0010016;
//(*desc="membrane-thickness", type="instance"*)  parameter real mem_th = 2;

(*desc="threshold_pressure", type="instance"*) parameter real threshold_pressure_kPa=103e3;
(*desc="threshold_pressure", type="instance"*) parameter real transition_pressure_kPa=6.8e3;

(*desc="threshold_multiplier", type="instance"*) parameter real w0_m=1.1;

(*desc="pn viscosity", type="instance"*)   parameter real nu_pn=18.03e-6;
(*desc="pn length", type="instance"*)         parameter real L_pn = 6e-3;
(*desc="pn cross-section", type="instance"*)  parameter real CROSS_SECTION_PN = 2;

real pixel_size;
real layer_height;

real H_layer, W_px;
real H_layer_pn, W_px_pn;
real Hm, Wm;
real Hn, Wn;
real dia_m, mem_th_m;
real R_valve, R_pn;

real P_lin, P_lin_start;

// membrane definitions
// typical dimension for a 3D printed valve
(*desc="membrane thickness", type="instance"*) parameter real mem_th = 20u;

// properties of PEGDA with 2% NPS
(*desc="Young's modulus", type="instance"*) parameter real mem_Emod = 7.7; // MPa

// estimating poisson's ratio using a typical value for epoxies
//   which tend to be 0.3 - 0.35
(*desc="Poisson's ratio", type="instance"*) parameter real mem_v = 0.3;

// membrane radius
//(*desc="membrane radius", type="instance"*) parameter real mem_r_px = 20; // px

////
// these are used for large deflections
// these variables derive from the Karman's large circular plate deflections

// currently m and N are based on a 2.5 mm radius - 100 um thickness membrane
// 02-02-24

(*desc="Karman fitting variable m", type="instance"*) parameter real m_fit = 0.41795 ;

// this comes from the original equation where N = 10^n
(*desc="Karman fitting variable N", type="instance"*) parameter real N_fit = 1.6020 ;

(*desc="fluid chamber height", type="instance"*) parameter real fl_ch_h = 20u; // meters
(*desc="pneumatic chamber height", type="instance"*) parameter real pn_ch_h = 100u; // meters

real p_c;
real D;
real w0_v;
real w0;
real cap;
real mem_r;

branch (fl_m, pn_m) q_cap ;

branch (fl_in, fl_m) fl_ib;
branch (fl_m, fl_out) fl_ob;
branch (pn_in, pn_m) pn_ib;
//branch (pn_m, pn_out) pn_ob;

analog begin

    pixel_size = 7.6u;
    layer_height = 10u;

    begin
    if (CROSS_SECTION == 1) begin
        // standard 1
        H_layer = 5;
        W_px = 6;
    end
    else if (CROSS_SECTION == 2) begin
        // standard 2
        H_layer = 8;
        W_px = 14;
    end
    end

    begin
    if (CROSS_SECTION_PN == 1) begin
        // standard 1
        H_layer_pn = 5;
        W_px_pn    = 6;
    end
    else if (CROSS_SECTION_PN == 2) begin
        // standard 2
        H_layer_pn = 8;
        W_px_pn    = 14;
    end
    end

    // Valve standard size 20px
    dia_m = pixel_size*valve_diameter_px;
    mem_th_m = pixel_size*mem_th;

    // converts the channel size to meters
    Hm = H_layer*layer_height;
    Wm = W_px*pixel_size;

    R_valve = (12*nu*L)/(1 - 0.63*(Hm/Wm)) * 1/(Hm*Hm*Hm/Wm);

    Hn = H_layer_pn*layer_height;
    Wn = W_px_pn*pixel_size;

    R_pn    = (12*nu_pn*L_pn)/(1 - 0.63*(Hn/Wn)) * 1/(Hn*Hn*Hn/Wn);

    // linear region of valve transition
    P_lin = 0.5*transition_pressure_kPa ;
    P_lin_start = threshold_pressure_kPa - P_lin;

    // Capacitance calcs
    mem_r = valve_diameter_px*pixel_size /2;

    cap = 3.141*pow(mem_r, 6)/(16*mem_Emod*pow(mem_th,3)) * (1 - mem_v*mem_v) ;

    D = mem_Emod*pow(mem_th, 3)/(12*(1-mem_v*mem_v)) ;
    p_c = 3.141*pow(mem_r,2)*fl_ch_h*0.70*tanh(V(q_cap)/2000) ;

    w0_v = fl_ch_h*64*D/pow(mem_r, 4) ;

    w0   = V(q_cap)*pow(mem_r, 4)/(64*D);
    //
    // Contribution statements
    //
    V(pn_ib) <+ 0;
    //I(pn_ob) <+ 0;

    V(fl_ob) <+ 0;

    // switch ----------------
    // Pressure above theshold
    if (V(pn_in) > threshold_pressure_kPa) begin
        I(fl_ib) <+ 0;
        //I(fl_ob) <+ 0;
        //V(c_out) <+ V(c_in);
    end else if (threshold_pressure_kPa - V(pn_in) <= P_lin) begin
        I(fl_ib) <+ V(fl_ib)/R_valve - \
            V(fl_ib)/R_valve * ((V(pn_in)-P_lin_start)/(threshold_pressure_kPa-P_lin_start));
       //V(c_out) <+ V(c_in);
    end else begin
        I(fl_ib) <+ V(fl_ib)/R_valve;
        //V(c_out) <+ V(c_in);
    end

    //if (V(q_cap) > (w0_v*1.1 )) begin
    //    I(fl_ib) <+ 0;
    //    //V(fl_ob) <+ 0;
    //    //I(fl_ob) <+ 0;
    //    //V(c_out) <+ V(c_in);
    //end else if (V(q_cap) >= w0_v) begin
    //    I(fl_ib) <+ V(fl_ib)/R_valve - \
    //        //V(fl_ib)/R_valve * ((V(pn_in)-P_lin_start)/(threshold_pressure_kPa-P_lin_start));
    //        V(fl_ib)/R_valve * (V(q_cap)-w0_v)/(w0_v*(0.1));
    //    //V(c_out) <+ V(c_in);
    //end
    //else begin
    //    I(fl_ib) <+ V(fl_ib)/R_valve;
    //    //V(fl_ob) <+ 0;
    //    //V(c_out) <+ V(c_in);
    //end

    I(q_cap) <+ ddt(p_c) ;

end // end analog

endmodule
