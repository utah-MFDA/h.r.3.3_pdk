//`include "nature_fluid_dynamics.vams"
`include "disciplines.vams"
`include "constants.vams"

//Capacitor
//
// unfinished
//

module membrane_cap_20pxV_nlin_5(p, n);
  electrical p, n;

  inout p, n;

  ////
  // these variables are used for small deflections

  // typical dimension for a 3D printed valve
  (*desc="membrane thickness", type="instance"*) parameter real mem_th = 20u;

  // properties of PEGDA with 2% NPS
  (*desc="Young's modulus", type="instance"*) parameter real mem_Emod = 7.7e6; // MPa

  // estimating poisson's ratio using a typical value for epoxies
  //   which tend to be 0.3 - 0.35
  (*desc="Poisson's ratio", type="instance"*) parameter real mem_v = 0.3;

  // membrane radius
  (*desc="membrane radius", type="instance"*) parameter real mem_r = 100u; // meters

  ////
  // these are used for large deflections
  // these variables derive from the Karman's large circular plate deflections

  (*desc="fluid chamber height", type="instance"*) parameter real fl_ch_h = 20u; // meters
  (*desc="pneumatic chamber height", type="instance"*) parameter real pn_ch_h = 100u; // meters

  branch (n, p) q_cap ;
  real p_c;

  real D;

  real R;
  real w0_v;
  real cap;
  real vol_rd;
  real vol_int;

  (*desc="valve Resistance", type="instance"*) parameter real C_res = 0;
  (*desc="viscosity", type="instance"*) parameter real nu = 0.0010016;

  analog
  begin

    // circuilar membrane
    D = mem_Emod*pow(mem_th, 3)/(12*(1-mem_v*mem_v)) ;

    // deflection at center
    w0_v = fl_ch_h*64*D/(pow(mem_r,4)) ;

    cap = 3.141*pow(mem_r, 6)/(16*mem_Emod*pow(mem_th,3)) * (1 - mem_v*mem_v) ;

    begin
    if ((V(q_cap) < w0_v)) begin
      p_c = cap*V(q_cap) ;
    end
    else begin
     R = pow(fl_ch_h*64*D/V(q_cap), (1/4));
      p_c = 3.141*(1-mem_v*mem_v)/(16*mem_Emod*pow(mem_th,3))*pow(R, 6)*V(q_cap);
    end
    end

    I(q_cap) <+ ddt(p_c) ;

 end
endmodule
