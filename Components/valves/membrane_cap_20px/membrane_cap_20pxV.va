`include "nature_fluid_dynamics.vams"
`include "disciplines.vams"
`include "constants.vams"

//Capacitor

module membrane_cap_20pxV(p, n);
  electrical p,n;
  inout p,n;

  (*desc="Capacitance", type="instance" *) parameter real C=1p;
  real Q;

  analog
  begin
    //  Note:  It is explicitly assumed here that C is constant!
    // This is wrong if C is externally defined as some time- or
    // solution-dependent parameter.  Fortunately, Xyce doesn't let you
    // make parameters solution-dependent, and special coding is necessary
    // external to the device even to enable such a thing.
    Q=C*V(p,n);
    I(p,n) <+ ddt(Q);
  end
endmodule
