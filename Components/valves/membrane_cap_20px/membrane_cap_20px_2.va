`include "nature_fluid_dynamics.vams"
`include "disciplines.vams"
`include "constants.vams"

module membrane_cap_20px_2(fl_in, fl_out, pn_in) ;

inout fl_in, fl_out, pn_in;
fluidDynamics fl_in, fl_out, pn_in ;
fluidDynamics fl_c;
real cap;

// typical dimension for a 3D printed valve
(*desc="membrane thickness", type="instance"*) parameter real mem_th = 20u;

// properties of PEGDA with 2% NPS
(*desc="Young's modulus", type="instance"*) parameter real mem_Emod = 7.7; // MPa

// estimating poisson's ratio using a typical value for epoxies
//   which tend to be 0.3 - 0.35
(*desc="Poisson's ratio", type="instance"*) parameter real mem_v = 0.3;

// membrane radius
(*desc="membrane radius", type="instance"*) parameter real mem_r = 100u; // meters

(*desc="fluid chamber height", type="instance"*) parameter real fl_ch_h = 100u; // meters
(*desc="pneumatic chamber height", type="instance"*) parameter real pn_ch_h = 100u; // meters

branch (fl_c, pn_in) q_mem ;
real q;
real limit_fl;
real limit_pn;

analog begin

    limit_fl = 2*3.141*mem_r*fl_ch_h;
    limit_pn = 2*3.141*mem_r*pn_ch_h;

    // circuilar membrane
    // linear volume displacement
    cap = 3.141 * pow(mem_r, 6) * (1 - mem_v*mem_v)/(3.141*mem_Emod*pow(mem_th,3 ));

    q  = cap * pow(P(q_mem), 2) ;
    Qfl(q_mem) <+ ddt( q ) ;

end // end analog

endmodule
