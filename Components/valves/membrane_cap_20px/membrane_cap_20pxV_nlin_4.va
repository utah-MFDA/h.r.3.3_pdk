//`include "nature_fluid_dynamics.vams"
`include "disciplines.vams"
`include "constants.vams"

//Capacitor

module membrane_cap_20pxV_nlin_4(p, n);
  electrical p, n;
  //electrical n_gnd;
  //electrical p_i;
  //electrical n_cap;

  inout p, n;

  ////
  // these variables are used for small deflections

  // typical dimension for a 3D printed valve
  (*desc="membrane thickness", type="instance"*) parameter real mem_th = 20u;

  // properties of PEGDA with 2% NPS
  (*desc="Young's modulus", type="instance"*) parameter real mem_Emod = 7.7e6; // MPa

  // estimating poisson's ratio using a typical value for epoxies
  //   which tend to be 0.3 - 0.35
  (*desc="Poisson's ratio", type="instance"*) parameter real mem_v = 0.3;

  // membrane radius
  (*desc="membrane radius", type="instance"*) parameter real mem_r = 100u; // meters

  ////
  // these are used for large deflections
  // these variables derive from the Karman's large circular plate deflections

  (*desc="fluid chamber height", type="instance"*) parameter real fl_ch_h = 20u; // meters
  (*desc="pneumatic chamber height", type="instance"*) parameter real pn_ch_h = 100u; // meters

  //branch (n_cap, n) q_cap ;

  branch (p, n) q_cap ;
  //branch (p_i, n) q_cap ;
  //branch (p_i, p) q_res ;
  //branch (p, p_i) q_fl  ;
  real p_c;
  //real q;
  real D;
  //real Pr;
  real w0_v;
  real cap;
  real vol_rd;
  real vol_int;

  //real mfit_1;
  real r_rt; // root value for membrane
  //real vol_int;
  //real V_n;

  (*desc="valve Resistance", type="instance"*) parameter real C_res = 0;
  (*desc="viscosity", type="instance"*) parameter real nu = 0.0010016;

  analog
  begin

    // circuilar membrane
    D = mem_Emod*pow(mem_th, 3)/(12*(1-mem_v*mem_v)) ;

    // deflection at center
    //w0_v = abs(V(q_cap))*pow(mem_r, 4) / (64*D) ;
    w0_v = fl_ch_h*64*D/(pow(mem_r,4)) ;

    //$display("w0:", w0_v) ;
    //$display(w0_v);

    //linear capacitance
    cap = 3.141*pow(mem_r, 6)/(16*mem_Emod*pow(mem_th,3)) * (1 - mem_v*mem_v) ;

    /*
    begin
    if (V(q_cap)>0) begin
      r_rt  = mem_r*mem_r - 8 * sqrt(D*fl_ch_h/abs(V(q_cap))) ;
    end
    else if (V(q_cap)<0) begin
      r_rt  = mem_r*mem_r + 8 * sqrt(D*fl_ch_h/abs(V(q_cap))) ;
    end
    else begin
      r_rt = 0;
    end
    end
    */
    //r_rt = (mem_r*0.94) * tanh(V(q_cap)/3000) ;

    //$display(vol_int);
    // non-linear model
    // radius of curvature

    begin
    //if (w0_v < fl_ch_h) begin
    if ((V(q_cap) < w0_v)) begin
      p_c = cap*V(q_cap) ;
      //p_c = 3.141*pow(mem_r,2)*fl_ch_h*0.94*tanh(V(q_cap)/2000) ;
      //$display("linear");
      //$display(p_c);
    end
    else begin
      begin
      if (V(q_cap)>0) begin
        r_rt  = pow(mem_r,2) - 8 * sqrt(D*fl_ch_h/abs(V(q_cap)) ) ;
      end
      else if (V(q_cap)<0) begin
        r_rt  = pow(mem_r,2) + 8 * sqrt(D*fl_ch_h/abs(V(q_cap)) ) ;
      end
      else begin
        r_rt = 0 ;
      end
      end
      $display("root w:", r_rt, " vc:", V(q_cap));

      //vol_int = 2*3.141*(0.5*pow(r_rt,2) - (1/(2*pow(mem_r,2)))*pow(r_rt,4) + (1/(6*pow(mem_r,4)))*pow(r_rt,6)) ;
      //vol_int = 2*3.141*(0.5*pow(r_rt,2) - (1/(2*mem_r*mem_r))*pow(r_rt,4) + (1/(6*pow(mem_r,4)))*pow(r_rt,6)) * \
      //  pow(mem_r,4)/(64*D) ;
      //vol_rd  = 3.141*fl_ch_h*pow(r_rt, 2) ;

      //p_c = cap*V(q_cap) - vol_int*V(q_cap)*pow(mem_r,4)/(64*D) + 3.141*fl_ch_h*pow(r_rt,2) ;
      p_c = cap*V(q_cap) - \
        2*3.141*(0.5*pow(r_rt,2) - (1/(2*mem_r*mem_r))*pow(r_rt,4) + (1/(6*pow(mem_r,4)))*pow(r_rt,6)) * \
        V(q_cap)*pow(mem_r,4)/(64*D) + \
        3.141*fl_ch_h*pow(r_rt, 2) ;
      //p_c = cap*V(q_cap) - vol_int*V(q_cap) + vol_rd;
      //p_c = cap*V(q_cap);
      //p_c = 3.141*pow(mem_r,2)*fl_ch_h*tanh(V(q_cap)/2000);
      //$display("nonlinear");
      //$display("c", cap, " i", vol_int, " r", vol_rd);
    end
    end

    //$display("v cap") ;
    //$display(V(q_cap));

    $display("c_vol:", p_c, " V:", V(q_cap));
    //$display(cap) ;
    //$display(p_c) ;
    // 103e3 kpa is ~ 15 psi

    //p_c = 3.141*pow(mem_r,2)*fl_ch_h*0.94*tanh(V(q_cap)/2000) ;
    //p_c = cap*V(q_cap);

    I(q_cap) <+ ddt(p_c) ;
    //I(q_res) <+ V(q_res)/C_res ;
    //I(q_fl)  <+ ddt(p_c) ;

 end
endmodule
