//`include "nature_fluid_dynamics.vams"
`include "disciplines.vams"
`include "constants.vams"

//Capacitor

module membrane_cap_20pxV_nlin(p, n);
  electrical p,n;
  inout p,n;

  real cap;

  ////
  // these variables are used for small deflections

  // typical dimension for a 3D printed valve
  (*desc="membrane thickness", type="instance"*) parameter real mem_th = 20u;

  // properties of PEGDA with 2% NPS
  (*desc="Young's modulus", type="instance"*) parameter real mem_Emod = 7.7; // MPa

  // estimating poisson's ratio using a typical value for epoxies
  //   which tend to be 0.3 - 0.35
  (*desc="Poisson's ratio", type="instance"*) parameter real mem_v = 0.3;

  // membrane radius
  (*desc="membrane radius", type="instance"*) parameter real mem_r = 100u; // meters

  ////
  // these are used for large deflections
  // these variables derive from the Karman's large circular plate deflections

  // currently m and N are based on a 2.5 mm radius - 100 um thickness membrane
  // 02-02-24

  (*desc="Karman fitting variable m", type="instance"*) parameter real m_fit = 0.41795 ;

  // this comes from the original equation where N = 10^n
  (*desc="Karman fitting variable N", type="instance"*) parameter real N_fit = 1.6020 ;

  branch (p, n) q_cap ;
  real p_c;
  real q;
  real D;
  real mfit_1;

  analog
  begin

    // circuilar membrane
    D = 3.141 * pow(mem_r, 6) * (1 - mem_v*mem_v)/(3.141*mem_Emod*pow(mem_th,3 ));
    //$display(cap);

    mfit_1 = m_fit -1 ;

    begin
    if (V(n) > 0 ) begin
      cap = m_fit*N_fit*pow(V(n), mfit_1) * 1e-3;
      $display(cap) ;
    end
    else if (V(n) < 0 ) begin
      cap = m_fit*N_fit*pow(-V(n), mfit_1) * 1e-3;
      $display(cap) ;
    end
    else begin
      cap = 1/D;
    end
    end

    // 103e3 kpa is ~ 15 psi

    p_c = cap*V(q_cap);

    I(q_cap) <+ ddt(p_c) ;
  end
endmodule
