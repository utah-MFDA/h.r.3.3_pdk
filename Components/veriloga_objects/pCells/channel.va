`include "nature_fluid_dynamics.vams"
`include "disciplines.vams"
`include "constants.vams"

module channel(fl_in, fl_out, c_in, c_out);

inout fl_in, fl_out;
fluidDynamics fl_in, fl_out;
branch (fl_in, fl_out) fl_br ;

inout c_in, c_out;
concentration c_in, c_out;
concentration cv1, cv2;

(*desc="channel length", type="instance"*) parameter real length=5m;

// These values assume 7.6u px and 10u layers
(*desc="cross-section width in px", type="instance"*) parameter real channel_w=14;
(*desc="cross-section height in layers", type="instance"*) parameter real channel_h=10;

(*desc="viscosity", type="instance"*) parameter real nu=0.0010016;

(*desc="capacitance concentration", type="instance"*) parameter real ccap=100u ;
(*desc="capacitance ground", type="instance"*) parameter real gcap=100n ;

real pixel_size;
real layer_height;
real W, H, L;
real R;
real ch_width_pixels;
real ch_height_layers;

real cqi ;
real cqo ;
real cqi_g ;
real cqo_g ;

concentration gnd;
ground gnd;

analog begin

   @(initial_instance)
   begin : initial_instance
      pixel_size = 7.6u;
      layer_height = 10u;

      W = channel_w * pixel_size ;
      H = channel_h * layer_height ;
      L = length ;

      R = (12*nu*L) / (1 - 0.63*(H/W)) * 1/(H*H*H*W);
   end

   Qfl(fl_br) <+ P(fl_br)/R;

   C(cv1, cv2) <+ 0 ;
   cqi = ccap*C(c_in,  cv1) ;
   cqo = ccap*C(c_out, cv2);
   Ci(c_in,  cv1) <+ ddt(cqi) ;
   Ci(c_out, cv2) <+ ddt(cqo) ;

   cqi_g = gcap*C(cv1) ;
   cqo_g = gcap*C(cv2) ;
   Ci(cv1, gnd) <+ ddt(cqi_g) ;
   Ci(cv2, gnd) <+ ddt(cqo_g) ;
end

endmodule
