`include "nature_fluid_dynamics.vams"
`include "disciplines.vams"
`include "constants.vams"

module channel_flow(fl_in, fl_out) ;
//, c_in, c_out);

inout fl_in, fl_out;
fluidDynamics fl_in, fl_out;
branch (fl_in, fl_out) fl_br ;

//inout c_in, c_out;
//concentration c_in, c_out;
//concentration cv1, cv2;
//branch (c_in, c_out) chem ;

(*desc="cross-section", type="instance"*) parameter real length=5m;
(*desc="cross-section", type="instance"*) parameter real CROSS_SECTION=1;
(*desc="cross-section", type="instance"*) parameter real NU=0.0010016;

//(*desc="capacitance concentration", type="instance"*) parameter real ccap=100u
//(*desc="resistance concentration", type="instance"*) parameter real rcap=100u

real pixel_size;
real layer_height;
real W, H, L;
real R;
real ch_width_pixels;
real ch_height_layers;

ground gnd;

analog begin

   @(initial_instance)
   begin : initial_instance
      pixel_size = 7.6u;
      layer_height = 10u;

      begin
      if (CROSS_SECTION == 1) begin
         ch_width_pixels = 14;
         ch_height_layers= 10;
      end
      else if(CROSS_SECTION == 2) begin
         ch_width_pixels = 6;
         ch_height_layers= 5;
      end
      else if(CROSS_SECTION == 3) begin
         ch_width_pixels = 28;
         ch_height_layers= 20;
      end
      else if(CROSS_SECTION == 4) begin
         ch_width_pixels = 42;
         ch_height_layers= 30;
      end
      else if(CROSS_SECTION == 5) begin
         ch_width_pixels = 70;
         ch_height_layers= 50;
      end
      end

      W = pixel_size * ch_width_pixels;
      H = layer_height*ch_height_layers;
      L = length;

      R = (12*NU*L) / (1 - 0.63*(H/W)) * 1/(H*H*H*W);
   end
   //$display("resistance:");
   //$display(R);
   //begin
   //if (P(fl_br) >= 0) begin
   Qfl(fl_br) <+ P(fl_br)/R;
   //end
   //else begin
      //Qfl(fl_br) <+ - abs(P(fl_br))/R;
   //end
   //end
   //for (i = vec_size-1; i >= 0; i = i - 1) begin
   //   V(c_out[i]) <+ V(c_in[i]);
   //end // end FOR LOOP
   //C(chem_con_d) <+ 0 ;//C(c_in, gnd);
   //C(c_in, c_out) <+ 0 ;
   //C(cv1, gnd) <+ C(c_in) ;
   //C(cv2, gnd) <+ C(c_out) ;
   //C(c_out, gnd) <+ C(c_in, gnd);
   //begin
   //if (P(fl_br) >= 0) begin
      //C(c_out) <+ C(c_in);
   //end
   //else begin
      //C(c_in) <+ C(c_out);
   //end
   //end
end

endmodule
