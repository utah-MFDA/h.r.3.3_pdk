`include "nature_fluid_dynamics.vams"
`include "disciplines.vams"
`include "constants.vams"

module serpentine_25px_0(fl_in, fl_out, c_in, c_out);

inout fl_in, fl_out, c_in, c_out;
concentration c_in, c_out;
fluidDynamics fl_in, fl_out;

(*desc="length", type="instance"*) parameter real length=0.380m;
(*desc="length", type="instance"*) parameter real CROSS_SECTION=1;
(*desc="length", type="instance"*) parameter real NU=0.0010016;

real pixel_size;
real layer_height;
real W, H, L;
real R;
real ch_width_pixels, ch_height_layers;

ground gnd;

analog begin
   @(initial_instance)
   begin : initial_instance

      //
      // -- print resolution definitions
      //
      pixel_size = 7.6u;
      layer_height = 10u;

      //
      // -- adjust resistance based on cross section
      //
      begin
      if (CROSS_SECTION == 1) begin
         ch_width_pixels = 14;
         ch_height_layers= 10;
      end
      else if(CROSS_SECTION == 2) begin
         ch_width_pixels = 6;
         ch_height_layers= 5;
      end
      end

      W = pixel_size * ch_width_pixels;
      H = layer_height*ch_height_layers;
      L = length;

      R = (12*NU*L) / (1 - 0.63*(H/W)) * 1/(H*H*H*W);
     // $display("resistance:");
     // $display(R);
   end //end initial_instance

   Qfl(fl_in, fl_out) <+ P(fl_in, fl_out)/R;

   if ($port_connected(c_in) && $port_connected(c_out))
   begin
      C(c_out) <+ C(c_in);
   end
end

endmodule
