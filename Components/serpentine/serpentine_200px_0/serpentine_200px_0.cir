* serpentine 200px subcir

.SUBCKT serpentine_sub_200px 11 12 80 82 PARAMS: cross_sect=1

Ychannel c1 11 12 80 82 length=16.416m cross_section=cross_sect

.ENDS
