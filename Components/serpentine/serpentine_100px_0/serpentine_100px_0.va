`include "nature_fluid_dynamics.vams"
`include "disciplines.vams"
`include "constants.vams"

module serpentine_100px_0(fl_in, fl_out, c_in, c_out);

inout fl_in, fl_out, c_in, c_out;
concentration c_in, c_out;
branch (c_in, c_out) chem;

fluidDynamics fl_in, fl_out;
branch (fl_in, fl_out) fflow;

(*desc="cross-section", type="instance"*) parameter real length=3.8m;
(*desc="cross-section", type="instance"*) parameter real CROSS_SECTION=1;
(*desc="cross-section", type="instance"*) parameter real NU=0.0010016;

real pixel_size;
real layer_height;
real W, H, L;
real R;
real ch_width_pixels, ch_height_layers;

ground gnd;

analog begin

   @(initial_instance)
   begin : initial_instance

      //
      // -- print resolution definitions
      //
      pixel_size = 7.6u;
      layer_height = 10u;

      //
      // -- adjust resistance based on cross section
      //
      begin
      if (CROSS_SECTION == 1) begin
         ch_width_pixels = 14;
         ch_height_layers= 10;
      end
      else if(CROSS_SECTION == 2) begin
         ch_width_pixels = 6;
         ch_height_layers= 5;
      end
      end

      W = pixel_size * ch_width_pixels;
      H = layer_height*ch_height_layers;
      L = length;

      R = (12*NU*L) / (1 - 0.63*(H/W)) * 1/(H*H*H*W);
      //$display("resistance:");
      //$display(R);
   end // end initial_model

   Qfl(fflow) <+ P(fl_in, fl_out)/R;

   //V(c_out, c_in) <+ 0;
   if ($port_connected(c_in) && $port_connected(c_out))
   begin
      C(c_out) <+ C(c_in);
   end
   //I(chem) <+ 0;
end

endmodule
