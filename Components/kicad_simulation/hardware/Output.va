`include "nature_fluid_dynamics.vams"
`include "disciplines.vams"
`include "constants.vams"

//module Output(fl_out, c_out);
module Output(c_out, gnd);

// vector test
//parameter integer vec_size = 1;

//input fl_out;
//output [0:vec_size-1] c_out;
input c_out;
output gnd;
//fluidDynamics fl_out;
concentration c_out, c_term;

//ground gnd;

//integer i;

analog begin
   //P(fl_out, gnd) <+ 0;
   C(c_out, gnd)  <+ - C(c_out) ;
   //I(c_out)  <+ 0;
   //for (i = vec_size-1; i >= 0; i = i - 1) begin
   //   V(c_out[i])  <+ chemConcentration;
   //end // end FOR LOOP

end

endmodule
