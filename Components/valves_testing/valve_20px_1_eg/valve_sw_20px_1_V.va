//`include "nature_fluid_dynamics.vams"
`include "disciplines.vams"
`include "constants.vams"

module valve_sw_20px_1_V(fl_in, fl_out,  pn_in, pn_out);
//c_in, c_out,

inout fl_in, fl_out;
//inout c_in, c_out;
inout pn_in, pn_out;

electrical fl_in, fl_out;
//electrical c_in, c_out;
electrical pn_in, pn_out;

(*desc="valve-diameter", type="instance"*) parameter real valve_diameter_px=200;
(*desc="length", type="instance"*)         parameter real L = 6e-3;
(*desc="cross-section", type="instance"*)  parameter real CROSS_SECTION = 2;
(*desc="viscosity", type="instance"*)      parameter real nu=0.0010016;
(*desc="membrane-thickness", type="instance"*)  parameter real mem_th = 2;

real pixel_size;
real layer_height;
(*desc="threshold_pressure", type="instance"*) parameter real threshold_pressure_kPa=103e3;
(*desc="threshold_pressure", type="instance"*) parameter real transition_pressure_kPa=6.8e3;

real H_layer, W_px;
real Hm, Wm, Lm;
real dia_m, mem_th_m;
real R_valve;

real P_lin, P_lin_start;

analog begin

    pixel_size = 7.6u;
    layer_height = 10u;

    //threshold_pressure_PSI = 15;
    //threshold_pressure_kPa = 103k;

    begin
    if (CROSS_SECTION == 1) begin
        // standard 1
        H_layer = 5;
        W_px = 6;
    end
    else if (CROSS_SECTION == 2) begin
        // standard 2
        H_layer = 8;
        W_px = 14;
    end
    end

    // Valve standard size 20px
    dia_m = pixel_size*valve_diameter_px;
    mem_th_m = pixel_size*mem_th;

    // converts the channel size to meters
    Lm = L;
    Hm = H_layer*layer_height;
    Wm = W_px*pixel_size;

    R_valve = (12*nu*Lm)/(1 - 0.63*(Hm/Wm)) * 1/(Hm*Hm*Hm/Wm);

    //R_valve = 1;
    //$display(R_valve);

    // linear region of valve transition
    P_lin = 0.5*transition_pressure_kPa ;
    P_lin_start = threshold_pressure_kPa - P_lin;

    // Pressure above theshold
    if (V(pn_in) > threshold_pressure_kPa) begin
        I(fl_in, fl_out) <+ 0;
        //V(c_out) <+ V(c_in);
    end else if (threshold_pressure_kPa - V(pn_in) <= P_lin) begin
        I(fl_in, fl_out) <+ V(fl_in, fl_out)/R_valve - \
            V(fl_in, fl_out)/R_valve * ((V(pn_in)-P_lin_start)/(threshold_pressure_kPa-P_lin_start));
        //V(c_out) <+ V(c_in);
    end else begin
        I(fl_in, fl_out) <+ V(fl_in, fl_out)/R_valve;
        //V(c_out) <+ V(c_in);
    end

    //if (P(pn_in) >= threshold_pressure_PSI)
    //    targ_q = P(fl_in, fl_out)/R_valve;
    //else
    //    targ_q = 0 ;

    //else if (threshold_pressure_PSI - P(pn_in) <= 2)
    //    Q(fl_in, fl_out) <+ P(fl_in, fl_out)/R_valve - P(fl_in, fl_out)/R_valve*((P(pn_in)-13)/(threshold_pressure_PSI-13));

    //Q(fl_in, fl_out) <+ ddt(targ_q - q_prev);

    //q_prev    = q_present;
    //q_present = ddt(targ_q - q_prev);

end // end analog

endmodule
